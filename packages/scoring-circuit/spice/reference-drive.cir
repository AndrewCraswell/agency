* BP-101 REF5025-to-ADS8881 reference-drive transient screen.
* This is an explicitly bounded behavioral model, not a vendor silicon model.
* BREF represents only a 2.5 V regulated target above a declared input headroom.
* RREFOUT, capacitor effective values, ESR, and ADC reference-load pulses are
* supplied by the runner. No result is REF5025 or ADS8881 performance proof.
VIN vin_source 0 {{SUPPLY_SOURCE}}
RINPUT vin_source vin {{INPUT_SOURCE_OHMS}}
CREFIN vin 0 {{REF_INPUT_CAP_UF}}u
BREF ref_source 0 V={min(2.5,max(0,V(vin)-1.0))}
RREFOUT ref_source refout {{REF_OUTPUT_OHMS}}
RREFREGESR refout refreg_cap {{REF_REG_ESR_OHMS}}
CREFREG refreg_cap 0 {{REF_REG_CAP_UF}}u
CREFHF refout 0 0.1u
RREFSAR refout adcref {{FEED_OHMS}}
RADCESR adcref adcref_cap {{ADC_CAP_ESR_OHMS}}
CADCREF adcref_cap 0 {{ADC_CAP_UF}}u
IADCLOAD adcref 0 {{ADC_LOAD_SOURCE}}
.tran {{TIME_STEP}} {{STOP_TIME}} uic
{{MEASUREMENTS}}
.print tran v(vin) v(refout) v(adcref)
.end
