Primary regulator input-network screen, not a converter or USB compliance model
* Cable R/L and source slew are engineering scenarios, not measured or guaranteed.
* C values are effective lumped capacitance including local bypasses.
* No regulator control loop, USB source current limit, PD controller or TVS modeled.
* Low-voltage test: 4.75V source, 0.5ohm/2uH lead, 6uF effective input bank.
VLOW slow 0 4.75
RLOW slow llow 0.5
LLOW llow vinlow 2u
RCLOW vinlow clow 0.01
CLOW clow 0 6u
ILOAD vinlow 0 PWL(0 0.01 100u 0.01 101u 0.524 300u 0.524 301u 0.01 600u 0.01)
* Low-resistance attachment: ideal 5V source ramp in 0.1us, 0.05ohm/2uH lead.
VATT satt 0 PWL(0 0 10u 0 10.1u 5 600u 5)
RATT satt latt 0.05
LATT latt vinatt 2u
RCATT vinatt catt 0.01
CATT catt 0 8.58u
* Example PD transition: 5V to 20V over 500us, 0.05ohm/2uH lead.
* 4uF at high voltage is a bias-reduced scenario; capacitance is held constant.
VPD spd 0 PWL(0 5 50u 5 550u 20 800u 20)
RPD spd lpd 0.05
LPD lpd vinpd 2u
RCPD vinpd cpd 0.01
CPD cpd 0 4u
.control
set noaskquit
tran 10n 800u
meas tran laptop_min MIN v(vinlow) FROM=100u TO=300u
meas tran laptop_settled FIND v(vinlow) AT=290u
meas tran attach_peak MAX v(vinatt) FROM=10u TO=200u
meas tran transition_peak MAX v(vinpd) FROM=50u TO=800u
quit
.endc
.end
