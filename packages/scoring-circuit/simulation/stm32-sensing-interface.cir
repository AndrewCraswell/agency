STM32 USB scoring platform - bounded continuity and reset-bias characterization
* Actual candidate values: Nexperia 74LVC125APW -> 220R -> conductor -> 390R -> SENSE,
* with 1k SENSE pull-down. Seven identical channels; no new external comparator.
* Comparator uses internal VREFINT/2, HYST=1. Conservative decision envelope:
* 0.556..0.651 V from DS12288 Rev6 VREFINT 1.182..1.232 V, scaler +/-10 mV,
* comparator +/-9 mV allowance and full 16 mV hysteresis allowance each way.
* Nexperia 74LVC125A Rev12 Table6: VOH >=2.25 V at VCC=3 V, 18 mA,
* -40..125 C; VOL <=0.8 V at 24 mA. Require CORE_3V3 >=3 V before acquisition.
* 121 uA leakage is an ENGINEERING STRESS (100 uA clamp + 20 uA buffer +
* 1 uA MCU allowance), not a guaranteed BAT54S temperature limit. Nexperia
* specifies 2 uA at 25 C / 25 V; hot curves are typical only. Bench work remains.
* 10 nF cable and 30 pF input are chosen load stresses, not FIE certification.
* Behavioral sources do not model clamp conduction, unpowered/external faults,
* full weapon truth tables, ADC accuracy, comparator delays or capture firmware.

* Open-input worst pull-down tolerance and positive leakage stress.
Iopen 0 open_sense 121u
Ropen open_sense 0 1010

* Closed pair: both conductor sense branches load the source. 500R is a
* continuity stress only, not proof of per-weapon resistance discrimination.
Vweak weak_driver 0 2.25
Rweak_drive weak_driver weak_a 222.2
Rweak_contact weak_a weak_b 500
Rweak_series_a weak_a weak_sense_a 393.9
Rweak_series_b weak_b weak_sense_b 393.9
Rweak_pull_a weak_sense_a 0 990
Rweak_pull_b weak_sense_b 0 990
Iweak_a weak_sense_a 0 121u
Iweak_b weak_sense_b 0 121u

.subckt nominal_pair driver contact_sense params: contact=0.01
Rdrive driver a 220
Rcontact a b {contact}
Rseries_a a sense_a 390
Rpull_a sense_a 0 1000
Rseries_b b contact_sense 390
Rpull_b contact_sense 0 1000
.ends nominal_pair
Vnom nominal_driver 0 3.3
Xzero nominal_driver zero_sense nominal_pair contact=0.01
Xhundred nominal_driver hundred_sense nominal_pair contact=100
Xfivehundred nominal_driver fivehundred_sense nominal_pair contact=500

* Opposed own-board outputs: highest supply, both minimum source resistors.
Vshort short_driver 0 3.6
Rshort_source short_driver short_line 217.8
Rshort_sink short_line 0 217.8

* Maximum own-board voltage into a grounded conductor, minimum 220R tolerance.
* This also bounds initial charging current into an empty cable capacitor.
Vgrounded grounded_driver 0 3.6
Rgrounded grounded_driver 0 217.8

* Reset defaults with buffer input leakage directed AGAINST each pull.
Vlogic logic_supply 0 3.0
Roe logic_supply oe_n 10100
Ioe oe_n 0 20u
Rdrive_default drive_default 0 10100
Idrive_default 0 drive_default 20u

* Active-low discharge of one cable: low-output bound is deliberately 0.8 V.
Vclear clear_driver 0 PWL(0 3.3 100u 3.3 100.01u 0.8 400u 0.8)
Rclear clear_driver clear_line 222.2
Cclear_cable clear_line 0 10n
Rclear_series clear_line clear_sense 386.1
Rclear_pull clear_sense 0 1010
Cclear_input clear_sense 0 30p

* Passive contact release for comparison: sense loading must discharge cable.
* This deliberately exposes the pulse tail, not a passed scoring timing test.
Vrelease release_driver 0 3.6
Rrelease_drive release_driver release_a 220
Rrelease_source_series release_a release_source_sense 390
Rrelease_source_pull release_source_sense 0 1000
Vcontact contact_control 0 PWL(0 1 100u 1 100.01u 0 400u 0)
Scontact release_a release_b contact_control 0 contact_switch
.model contact_switch SW(Ron=0.01 Roff=1e12 Vt=0.5 Vh=0)
Crelease_cable release_b 0 10n
Rrelease_series release_b release_sense 393.9
Rrelease_pull release_sense 0 1010
* Source-positive leakage opposes decay after the contact opens.
Irelease_leak 0 release_sense 121u
Crelease_input release_sense 0 30p

.control
set noaskquit
tran 0.02u 400u
meas tran open_input MAX v(open_sense)
meas tran weak_contact MIN v(weak_sense_b)
meas tran weak_driver_current MAX i(Vweak)
meas tran nominal_zero FIND v(zero_sense) AT=50u
meas tran nominal_100 FIND v(hundred_sense) AT=50u
meas tran nominal_500 FIND v(fivehundred_sense) AT=50u
meas tran opposed_current MAX i(Vshort)
meas tran grounded_conductor_current MAX i(Vgrounded)
meas tran reset_disabled MIN v(oe_n)
meas tran reset_drive_low MAX v(drive_default)
meas tran active_clear_low FIND v(clear_sense) AT=150u
meas tran active_clear_delay TRIG v(clear_driver) VAL=1.55 FALL=1 TARG v(clear_sense) VAL=0.556 FALL=1
meas tran passive_release_tail TRIG v(contact_control) VAL=0.5 FALL=1 TARG v(release_sense) VAL=0.556 FALL=1
quit
.endc
.end
